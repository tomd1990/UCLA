// Design: ee115c/Project11NEW
simulator lang=spectre
global 0
include "/w/class.1/ee/ee115v/ee115vta/gpdk/gpdk090/../../models/spectre/gpdk090.scs" section=NN

// gsclib090/XOR2X1/schematic
subckt XOR2X1 A B Y inh_VDD inh_VSS
    mp3 (n0 n2 net130 inh_VDD) gpdk090_pmos1v w=(360n) l=100n m=(1)*(1)
    mp1 (n2 B inh_VDD inh_VDD) gpdk090_pmos1v w=(360n) l=100n m=(1)*(1)
    mp4 (n1 B n0 inh_VDD) gpdk090_pmos1v w=(360n) l=100n m=(1)*(1)
    mp0 (n1 A inh_VDD inh_VDD) gpdk090_pmos1v w=(360n) l=100n m=(1)*(1)
    mp5 (Y n0 inh_VDD inh_VDD) gpdk090_pmos1v w=(650n) l=100n m=(1)*(1)
    mp2 (net130 n1 inh_VDD inh_VDD) gpdk090_pmos1v w=(360n) l=100n m=(1)*(1)
    mn1 (n2 B inh_VSS inh_VSS) gpdk090_nmos1v w=(240n) l=100n m=(1)*(1)
    mn0 (n1 A inh_VSS inh_VSS) gpdk090_nmos1v w=(240n) l=100n m=(1)*(1)
    mn5 (Y n0 inh_VSS inh_VSS) gpdk090_nmos1v w=(430n) l=100n m=(1)*(1)
    mn3 (n0 B net131 inh_VSS) gpdk090_nmos1v w=(240n) l=100n m=(1)*(1)
    mn4 (n0 n2 n1 inh_VSS) gpdk090_nmos1v w=(240n) l=100n m=(1)*(1)
    mn2 (net131 n1 inh_VSS inh_VSS) gpdk090_nmos1v w=(240n) l=100n m=(1)*(1)
ends XOR2X1

// gsclib090/INVX1/schematic
subckt INVX1 A Y inh_VDD inh_VSS
    mp0 (Y A inh_VDD inh_VDD) gpdk090_pmos1v w=(650n) l=100n m=(1)*(1)
    mn0 (Y A inh_VSS inh_VSS) gpdk090_nmos1v w=(430n) l=100n m=(1)*(1)
ends INVX1

// gsclib090/NOR2X1/schematic
subckt NOR2X1 A B Y inh_VDD inh_VSS
    mp1 (Y B net41 inh_VDD) gpdk090_pmos1v w=(650n) l=100n m=(1)*(1)
    mp0 (net41 A inh_VDD inh_VDD) gpdk090_pmos1v w=(650n) l=100n m=(1)*(1)
    mn1 (Y B inh_VSS inh_VSS) gpdk090_nmos1v w=(430n) l=100n m=(1)*(1)
    mn0 (Y A inh_VSS inh_VSS) gpdk090_nmos1v w=(430n) l=100n m=(1)*(1)
ends NOR2X1

// ee115c/CompS1NEW/schematic
subckt CompS1NEW GND M5 O1 T5 VDD
    I9 (M5 net14 VDD GND) INVX1
    I8 (T5 net14 O1 VDD GND) NOR2X1
ends CompS1NEW

// gsclib090/NOR3X1/schematic
subckt NOR3X1 A B C Y inh_VDD inh_VSS
    mp1 (n1 B n0 inh_VDD) gpdk090_pmos1v w=(650n) l=100n m=(1)*(1)
    mp2 (Y C n1 inh_VDD) gpdk090_pmos1v w=(650n) l=100n m=(1)*(1)
    mp0 (n0 A inh_VDD inh_VDD) gpdk090_pmos1v w=(650n) l=100n m=(1)*(1)
    mn0 (Y A inh_VSS inh_VSS) gpdk090_nmos1v w=(430n) l=100n m=(1)*(1)
    mn1 (Y B inh_VSS inh_VSS) gpdk090_nmos1v w=(430n) l=100n m=(1)*(1)
    mn2 (Y C inh_VSS inh_VSS) gpdk090_nmos1v w=(430n) l=100n m=(1)*(1)
ends NOR3X1

// gsclib090/AOI2BB2X1/schematic
subckt AOI2BB2X1 A0N A1N B0 B1 Y inh_VDD inh_VSS
    mp5 (Y B1 n4 inh_VDD) gpdk090_pmos1v w=(650n) l=100n m=(1)*(1)
    mp4 (Y B0 n4 inh_VDD) gpdk090_pmos1v w=(650n) l=100n m=(1)*(1)
    mp2 (n4 n0 inh_VDD inh_VDD) gpdk090_pmos1v w=(650n) l=100n m=(1)*(1)
    mp0 (n0 A0N inh_VDD inh_VDD) gpdk090_pmos1v w=(360n) l=100n m=(1)*(1)
    mp1 (n1 A1N inh_VDD inh_VDD) gpdk090_pmos1v w=(360n) l=100n m=(1)*(1)
    mp3 (n4 n1 inh_VDD inh_VDD) gpdk090_pmos1v w=(650n) l=100n m=(1)*(1)
    mn5 (n3 B1 inh_VSS inh_VSS) gpdk090_nmos1v w=(430n) l=100n m=(1)*(1)
    mn4 (Y B0 n3 inh_VSS) gpdk090_nmos1v w=(430n) l=100n m=(1)*(1)
    mn3 (Y n1 n2 inh_VSS) gpdk090_nmos1v w=(430n) l=100n m=(1)*(1)
    mn2 (n2 n0 inh_VSS inh_VSS) gpdk090_nmos1v w=(430n) l=100n m=(1)*(1)
    mn0 (n0 A0N inh_VSS inh_VSS) gpdk090_nmos1v w=(240n) l=100n m=(1)*(1)
    mn1 (n1 A1N inh_VSS inh_VSS) gpdk090_nmos1v w=(240n) l=100n m=(1)*(1)
ends AOI2BB2X1

// gsclib090/NOR4X1/schematic
subckt NOR4X1 A B C D Y inh_VDD inh_VSS
    mp1 (n1 B n0 inh_VDD) gpdk090_pmos1v w=(650n) l=100n m=(1)*(1)
    mp3 (Y D n2 inh_VDD) gpdk090_pmos1v w=(650n) l=100n m=(1)*(1)
    mp2 (n2 C n1 inh_VDD) gpdk090_pmos1v w=(650n) l=100n m=(1)*(1)
    mp0 (n0 A inh_VDD inh_VDD) gpdk090_pmos1v w=(650n) l=100n m=(1)*(1)
    mn2 (Y C inh_VSS inh_VSS) gpdk090_nmos1v w=(430n) l=100n m=(1)*(1)
    mn3 (Y D inh_VSS inh_VSS) gpdk090_nmos1v w=(430n) l=100n m=(1)*(1)
    mn0 (Y A inh_VSS inh_VSS) gpdk090_nmos1v w=(430n) l=100n m=(1)*(1)
    mn1 (Y B inh_VSS inh_VSS) gpdk090_nmos1v w=(430n) l=100n m=(1)*(1)
ends NOR4X1

// ee115c/Compcarry/schematic
subckt Compcarry A2 A3 A4 A5 B2 B3 B4 B5 C1 C2 C3 C4 GND VDD
    I83 (net5 net6 net8 C3 VDD GND) NOR3X1
    I73 (A2 B2 A2 B2 net10 VDD GND) AOI2BB2X1
    I87 (A4 B4 A4 B4 net6 VDD GND) AOI2BB2X1
    I88 (A5 B5 A5 B5 net8 VDD GND) AOI2BB2X1
    I72 (A3 B3 A3 B3 net5 VDD GND) AOI2BB2X1
    I79 (net6 net8 C2 VDD GND) NOR2X1
    I84 (net10 net5 net6 net8 C4 VDD GND) NOR4X1
    I80 (net8 C1 VDD GND) INVX1
ends Compcarry

// gsclib090/OA21X1/schematic
subckt OA21X1 A0 A1 B0 Y inh_VDD inh_VSS
    mp1 (net95 A1 net98 inh_VDD) gpdk090_pmos1v w=(360n) l=100n m=(1)*(1)
    mp0 (net98 A0 inh_VDD inh_VDD) gpdk090_pmos1v w=(360n) l=100n m=(1)*(1)
    mp3 (Y net95 inh_VDD inh_VDD) gpdk090_pmos1v w=(650n) l=100n m=(1)*(1)
    mp2 (net95 B0 inh_VDD inh_VDD) gpdk090_pmos1v w=(360n) l=100n m=(1)*(1)
    mn1 (net107 A1 inh_VSS inh_VSS) gpdk090_nmos1v w=(240n) l=100n m=(1)*(1)
    mn0 (net107 A0 inh_VSS inh_VSS) gpdk090_nmos1v w=(240n) l=100n m=(1)*(1)
    mn3 (Y net95 inh_VSS inh_VSS) gpdk090_nmos1v w=(430n) l=100n m=(1)*(1)
    mn2 (net95 B0 net107 inh_VSS) gpdk090_nmos1v w=(240n) l=100n m=(1)*(1)
ends OA21X1

// gsclib090/OR3X1/schematic
subckt OR3X1 A B C Y inh_VDD inh_VSS
    mp3 (Y n0 inh_VDD inh_VDD) gpdk090_pmos1v w=(650n) l=100n m=(1)*(1)
    mp1 (n2 B n1 inh_VDD) gpdk090_pmos1v w=(360n) l=100n m=(1)*(1)
    mp2 (n0 C n2 inh_VDD) gpdk090_pmos1v w=(360n) l=100n m=(1)*(1)
    mp0 (n1 A inh_VDD inh_VDD) gpdk090_pmos1v w=(360n) l=100n m=(1)*(1)
    mn3 (Y n0 inh_VSS inh_VSS) gpdk090_nmos1v w=(430n) l=100n m=(1)*(1)
    mn0 (n0 A inh_VSS inh_VSS) gpdk090_nmos1v w=(240n) l=100n m=(1)*(1)
    mn1 (n0 B inh_VSS inh_VSS) gpdk090_nmos1v w=(240n) l=100n m=(1)*(1)
    mn2 (n0 C inh_VSS inh_VSS) gpdk090_nmos1v w=(240n) l=100n m=(1)*(1)
ends OR3X1

// gsclib090/OR4X1/schematic
subckt OR4X1 A B C D Y inh_VDD inh_VSS
    mp4 (Y n0 inh_VDD inh_VDD) gpdk090_pmos1v w=(650n) l=100n m=(1)*(1)
    mp0 (n1 A inh_VDD inh_VDD) gpdk090_pmos1v w=(360n) l=100n m=(1)*(1)
    mp3 (n0 D n3 inh_VDD) gpdk090_pmos1v w=(360n) l=100n m=(1)*(1)
    mp1 (n2 B n1 inh_VDD) gpdk090_pmos1v w=(360n) l=100n m=(1)*(1)
    mp2 (n3 C n2 inh_VDD) gpdk090_pmos1v w=(360n) l=100n m=(1)*(1)
    mn4 (Y n0 inh_VSS inh_VSS) gpdk090_nmos1v w=(430n) l=100n m=(1)*(1)
    mn3 (n0 D inh_VSS inh_VSS) gpdk090_nmos1v w=(240n) l=100n m=(1)*(1)
    mn0 (n0 A inh_VSS inh_VSS) gpdk090_nmos1v w=(240n) l=100n m=(1)*(1)
    mn2 (n0 C inh_VSS inh_VSS) gpdk090_nmos1v w=(240n) l=100n m=(1)*(1)
    mn1 (n0 B inh_VSS inh_VSS) gpdk090_nmos1v w=(240n) l=100n m=(1)*(1)
ends OR4X1

// gsclib090/AND2X1/schematic
subckt AND2X1 A B Y inh_VDD inh_VSS
    mp1 (n0 B inh_VDD inh_VDD) gpdk090_pmos1v w=(360n) l=100n m=(1)*(1)
    mp0 (n0 A inh_VDD inh_VDD) gpdk090_pmos1v w=(360n) l=100n m=(1)*(1)
    mp2 (Y n0 inh_VDD inh_VDD) gpdk090_pmos1v w=(650n) l=100n m=(1)*(1)
    mn2 (Y n0 inh_VSS inh_VSS) gpdk090_nmos1v w=(430n) l=100n m=(1)*(1)
    mn0 (net127 B inh_VSS inh_VSS) gpdk090_nmos1v w=(240n) l=100n m=(1)*(1)
    mn1 (n0 A net127 inh_VSS) gpdk090_nmos1v w=(240n) l=100n m=(1)*(1)
ends AND2X1

// ee115c/carrystage3/schematic
subckt carrystage3 B1 B2 B3 B4 B6 GND VDD Y1 Y2 Y3 Y4
    I47 (B1 B2 B6 Y2 VDD GND) OA21X1
    I51 (B3 B2 B1 net10 VDD GND) OR3X1
    I52 (B4 B3 B2 B1 net11 VDD GND) OR4X1
    I54 (B6 net11 Y4 VDD GND) AND2X1
    I56 (B1 B6 Y1 VDD GND) AND2X1
    I53 (B6 net10 Y3 VDD GND) AND2X1
ends carrystage3

// ee115c/M51module222OLDY/schematic
subckt M51module222OLDY B5 GND M5 VDD Y
    I6 (B5 Y B5 Y M5 VDD GND) AOI2BB2X1
ends M51module222OLDY

// gsclib090/NAND2X1/schematic
subckt NAND2X1 A B Y inh_VDD inh_VSS
    mp1 (Y B inh_VDD inh_VDD) gpdk090_pmos1v w=(650n) l=100n m=(1)*(1)
    mp0 (Y A inh_VDD inh_VDD) gpdk090_pmos1v w=(650n) l=100n m=(1)*(1)
    mn1 (Y B n0 inh_VSS) gpdk090_nmos1v w=(430n) l=100n m=(1)*(1)
    mn0 (n0 A inh_VSS inh_VSS) gpdk090_nmos1v w=(430n) l=100n m=(1)*(1)
ends NAND2X1

// ee115c/CompS2NEW/schematic
subckt CompS2NEW A B C GND O VDD
    I3 (B net9 O VDD GND) NOR2X1
    I1 (A C net9 VDD GND) NAND2X1
ends CompS2NEW

// ee115c/NOR3X2/schematic
subckt NOR3X2 A B C Y inh_VDD inh_VSS
    mp1 (n1 B n0 inh_VDD) gpdk090_pmos1v w=(1.3u) l=100n m=(1)*(1)
    mp2 (Y C n1 inh_VDD) gpdk090_pmos1v w=(1.3u) l=100n m=(1)*(1)
    mp0 (n0 A inh_VDD inh_VDD) gpdk090_pmos1v w=(1.3u) l=100n m=(1)*(1)
    mn0 (Y A inh_VSS inh_VSS) gpdk090_nmos1v w=(860n) l=100n m=(1)*(1)
    mn1 (Y B inh_VSS inh_VSS) gpdk090_nmos1v w=(860n) l=100n m=(1)*(1)
    mn2 (Y C inh_VSS inh_VSS) gpdk090_nmos1v w=(860n) l=100n m=(1)*(1)
ends NOR3X2

// ee115c/NAND2X8/schematic
subckt NAND2X8 A B Y inh_VDD inh_VSS
    mp1 (Y B inh_VDD inh_VDD) gpdk090_pmos1v w=(5.2u) l=100n m=(1)*(1)
    mp0 (Y A inh_VDD inh_VDD) gpdk090_pmos1v w=(5.2u) l=100n m=(1)*(1)
    mn1 (Y B n0 inh_VSS) gpdk090_nmos1v w=(3.44u) l=100n m=(1)*(1)
    mn0 (n0 A inh_VSS inh_VSS) gpdk090_nmos1v w=(3.44u) l=100n m=(1)*(1)
ends NAND2X8

// ee115c/NOR2X2/schematic
subckt NOR2X2 A B Y inh_VDD inh_VSS
    mp1 (Y B net41 inh_VDD) gpdk090_pmos1v w=(1.3u) l=100n m=(1)*(1)
    mp0 (net41 A inh_VDD inh_VDD) gpdk090_pmos1v w=(1.3u) l=100n m=(1)*(1)
    mn1 (Y B inh_VSS inh_VSS) gpdk090_nmos1v w=(860n) l=100n m=(1)*(1)
    mn0 (Y A inh_VSS inh_VSS) gpdk090_nmos1v w=(860n) l=100n m=(1)*(1)
ends NOR2X2

// ee115c/finalstage/schematic
subckt finalstage C C1 C2 C3 C4 C5 GND VDD
    I18 (C5 C4 C3 net13 VDD GND) NOR3X2
    I20 (net13 net12 C VDD GND) NAND2X8
    I19 (C2 C1 net12 VDD GND) NOR2X2
ends finalstage

// ee115c/Project11NEW/schematic
I107 (X4 net075 M5 VDD GND) XOR2X1
I77 (GND M5 net048 T4 VDD) CompS1NEW
I76 (M2 M3 M4 M5 T1 T2 T3 T4 net026 net027 net046 net044 GND VDD) Compcarry
I90 (X0 X1 X2 X3 X5 GND VDD net036 net076 net054 net075) carrystage3
I104 (X3 GND M4 VDD net054) M51module222OLDY
I100 (X2 GND M3 VDD net076) M51module222OLDY
I99 (X1 GND M2 VDD net036) M51module222OLDY
I108 (X0 T0 net044 GND net042 VDD) CompS2NEW
I80 (M2 T1 net046 GND net043 VDD) CompS2NEW
I79 (M3 T2 net027 GND net040 VDD) CompS2NEW
I78 (M4 T3 net026 GND net050 VDD) CompS2NEW
I38 (OUT net042 net043 net040 net050 net048 GND VDD) finalstage
simulatorOptions options temp=27
